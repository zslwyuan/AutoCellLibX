.subckt add2sum VCC a0 a1 b0 b1 s0 s1 GND
Mg0_M0 _0_ a0 VCC VCC PMOS W=0.5u L=0.05u
Mg0_M1 VCC b0 _0_ VCC PMOS W=0.5u L=0.05u
Mg0_M2 g0#a_9_6# a0 GND GND NMOS W=0.5u L=0.05u
Mg0_M3 _0_ b0 g0#a_9_6# GND NMOS W=0.5u L=0.05u
Mg1_M0 VCC _0_ g1#a_2_6# VCC PMOS W=1u L=0.05u
Mg1_M1 g1#a_18_54# g1#a_12_41# VCC VCC PMOS W=1u L=0.05u
Mg1_M2 s1 g1#a_2_6# g1#a_18_54# VCC PMOS W=1u L=0.05u
Mg1_M3 g1#a_35_54# _0_ s1 VCC PMOS W=1u L=0.05u
Mg1_M4 VCC _1_ g1#a_35_54# VCC PMOS W=1u L=0.05u
Mg1_M5 g1#a_12_41# _1_ VCC VCC PMOS W=1u L=0.05u
Mg1_M6 GND _0_ g1#a_2_6# GND NMOS W=0.5u L=0.05u
Mg1_M7 g1#a_18_6# g1#a_12_41# GND GND NMOS W=0.5u L=0.05u
Mg1_M8 s1 _0_ g1#a_18_6# GND NMOS W=0.5u L=0.05u
Mg1_M9 g1#a_35_6# g1#a_2_6# s1 GND NMOS W=0.5u L=0.05u
Mg1_M10 GND _1_ g1#a_35_6# GND NMOS W=0.5u L=0.05u
Mg1_M11 g1#a_12_41# _1_ GND GND NMOS W=0.5u L=0.05u
Mg2_M0 VCC a1 g2#a_2_6# VCC PMOS W=1u L=0.05u
Mg2_M1 g2#a_18_54# g2#a_13_43# VCC VCC PMOS W=1u L=0.05u
Mg2_M2 _1_ a1 g2#a_18_54# VCC PMOS W=1u L=0.05u
Mg2_M3 g2#a_35_54# g2#a_2_6# _1_ VCC PMOS W=1u L=0.05u
Mg2_M4 VCC b1 g2#a_35_54# VCC PMOS W=1u L=0.05u
Mg2_M5 g2#a_13_43# b1 VCC VCC PMOS W=1u L=0.05u
Mg2_M6 GND a1 g2#a_2_6# GND NMOS W=0.5u L=0.05u
Mg2_M7 g2#a_18_6# g2#a_13_43# GND GND NMOS W=0.5u L=0.05u
Mg2_M8 _1_ g2#a_2_6# g2#a_18_6# GND NMOS W=0.5u L=0.05u
Mg2_M9 g2#a_35_6# a1 _1_ GND NMOS W=0.5u L=0.05u
Mg2_M10 GND b1 g2#a_35_6# GND NMOS W=0.5u L=0.05u
Mg2_M11 g2#a_13_43# b1 GND GND NMOS W=0.5u L=0.05u
Mg3_M0 VCC a0 g3#a_2_6# VCC PMOS W=1u L=0.05u
Mg3_M1 g3#a_18_54# g3#a_13_43# VCC VCC PMOS W=1u L=0.05u
Mg3_M2 s0 a0 g3#a_18_54# VCC PMOS W=1u L=0.05u
Mg3_M3 g3#a_35_54# g3#a_2_6# s0 VCC PMOS W=1u L=0.05u
Mg3_M4 VCC b0 g3#a_35_54# VCC PMOS W=1u L=0.05u
Mg3_M5 g3#a_13_43# b0 VCC VCC PMOS W=1u L=0.05u
Mg3_M6 GND a0 g3#a_2_6# GND NMOS W=0.5u L=0.05u
Mg3_M7 g3#a_18_6# g3#a_13_43# GND GND NMOS W=0.5u L=0.05u
Mg3_M8 s0 g3#a_2_6# g3#a_18_6# GND NMOS W=0.5u L=0.05u
Mg3_M9 g3#a_35_6# a0 s0 GND NMOS W=0.5u L=0.05u
Mg3_M10 GND b0 g3#a_35_6# GND NMOS W=0.5u L=0.05u
Mg3_M11 g3#a_13_43# b0 GND GND NMOS W=0.5u L=0.05u
.ends add2sum
