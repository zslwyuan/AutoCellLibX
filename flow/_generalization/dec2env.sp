.subckt dec2env VCC en s0 s1 y0 y1 y2 y3 GND
Mg0_M0 _02_ s0 VCC VCC PMOS W=0.5u L=0.05u
Mg0_M1 _02_ s0 GND GND NMOS W=0.25u L=0.05u
Mg1_M0 VCC s0 g1#a_2_64# VCC PMOS W=0.75u L=0.05u
Mg1_M1 g1#a_2_64# s0 VCC VCC PMOS W=0.75u L=0.05u
Mg1_M2 g1#a_25_64# _03_ g1#a_2_64# VCC PMOS W=0.75u L=0.05u
Mg1_M3 g1#a_2_64# _03_ g1#a_25_64# VCC PMOS W=0.75u L=0.05u
Mg1_M4 y0 s1 g1#a_25_64# VCC PMOS W=0.75u L=0.05u
Mg1_M5 g1#a_25_64# s1 y0 VCC PMOS W=0.75u L=0.05u
Mg1_M6 y0 s0 GND GND NMOS W=0.25u L=0.05u
Mg1_M7 GND _03_ y0 GND NMOS W=0.25u L=0.05u
Mg1_M8 y0 s1 GND GND NMOS W=0.25u L=0.05u
Mg2_M0 _03_ en VCC VCC PMOS W=0.5u L=0.05u
Mg2_M1 _03_ en GND GND NMOS W=0.25u L=0.05u
Mg3_M0 VCC _02_ g3#a_2_64# VCC PMOS W=0.75u L=0.05u
Mg3_M1 g3#a_2_64# _02_ VCC VCC PMOS W=0.75u L=0.05u
Mg3_M2 g3#a_25_64# _03_ g3#a_2_64# VCC PMOS W=0.75u L=0.05u
Mg3_M3 g3#a_2_64# _03_ g3#a_25_64# VCC PMOS W=0.75u L=0.05u
Mg3_M4 y1 s1 g3#a_25_64# VCC PMOS W=0.75u L=0.05u
Mg3_M5 g3#a_25_64# s1 y1 VCC PMOS W=0.75u L=0.05u
Mg3_M6 y1 _02_ GND GND NMOS W=0.25u L=0.05u
Mg3_M7 GND _03_ y1 GND NMOS W=0.25u L=0.05u
Mg3_M8 y1 s1 GND GND NMOS W=0.25u L=0.05u
Mg4_M0 _00_ en VCC VCC PMOS W=0.5u L=0.05u
Mg4_M1 VCC s1 _00_ VCC PMOS W=0.5u L=0.05u
Mg4_M2 g4#a_9_6# en GND GND NMOS W=0.5u L=0.05u
Mg4_M3 _00_ s1 g4#a_9_6# GND NMOS W=0.5u L=0.05u
Mg5_M0 g5#a_9_54# s0 VCC VCC PMOS W=1u L=0.05u
Mg5_M1 y2 _00_ g5#a_9_54# VCC PMOS W=1u L=0.05u
Mg5_M2 y2 s0 GND GND NMOS W=0.25u L=0.05u
Mg5_M3 GND _00_ y2 GND NMOS W=0.25u L=0.05u
Mg6_M0 _01_ s0 VCC VCC PMOS W=0.5u L=0.05u
Mg6_M1 VCC en _01_ VCC PMOS W=0.5u L=0.05u
Mg6_M2 _01_ s1 VCC VCC PMOS W=0.5u L=0.05u
Mg6_M3 g6#a_9_6# s0 GND GND NMOS W=0.75u L=0.05u
Mg6_M4 g6#a_14_6# en g6#a_9_6# GND NMOS W=0.75u L=0.05u
Mg6_M5 _01_ s1 g6#a_14_6# GND NMOS W=0.75u L=0.05u
Mg7_M0 y3 _01_ VCC VCC PMOS W=0.5u L=0.05u
Mg7_M1 y3 _01_ GND GND NMOS W=0.25u L=0.05u
.ends dec2env
